# Ansys Electronics Desktop project, version 15.0
materials:
  vacuum: permittivity=1

design HFSSDesign1 (HFSS, DrivenModal, model units mm)
options: Calculate_Lossy_Dielectrics
variables:
  X1 = 78.4823mm
  Y1 = 0mm
  Z1 = 0mm
  X2 = 109.5529mm
  Y2 = 5.1818mm
  Z2 = 0mm
  X3 = 125.193mm
  Y3 = 6.1553mm
  Z3 = 0mm
  X4 = 125.1082mm
  Y4 = 7.5181mm
  Z4 = 0mm
  X5 = 109.4681mm
  Y5 = 6.5447mm
  Z5 = 0mm
  X6 = 77.9919mm
  Y6 = 7.8478mm
  Z6 = 0mm
  X7 = 108.1864mm
  Y7 = 16.8264mm
  Z7 = 0mm
  X8 = 123.588mm
  Y8 = 19.7163mm
  Z8 = 0mm
  X9 = 123.3362mm
  Y9 = 21.0584mm
  Z9 = 0mm
  X10 = 107.9345mm
  Y10 = 18.1685mm
  Z10 = 0mm
  X11 = 76.5242mm
  Y11 = 15.6332mm
  Z11 = 0mm
  X12 = 105.419mm
  Y12 = 28.1943mm
  Z12 = 0mm
  X13 = 120.3656mm
  Y13 = 32.9016mm
  Z13 = 0mm
  X14 = 119.9554mm
  Y14 = 34.2041mm
  Z14 = 0mm
  X15 = 105.0088mm
  Y15 = 29.4967mm
  Z15 = 0mm
  X16 = 74.0986mm
  Y16 = 23.3083mm
  Z16 = 0mm
  X17 = 101.3552mm
  Y17 = 39.1439mm
  Z17 = 0mm
  X18 = 115.6713mm
  Y18 = 45.5166mm
  Z18 = 0mm
  X19 = 115.116mm
  Y19 = 46.764mm
  Z19 = 0mm
  X20 = 100.7999mm
  Y20 = 40.3914mm
  Z20 = 0mm
  X21 = 70.7948mm
  Y21 = 30.7303mm
  Z21 = 0mm
  X22 = 87.8916mm
  Y22 = 59.5827mm
  Z22 = 0mm
  X23 = 98.5254mm
  Y23 = 71.0927mm
  Z23 = 0mm
  X24 = 97.5225mm
  Y24 = 72.0194mm
  Z24 = 0mm
  X25 = 86.8886mm
  Y25 = 60.5093mm
  Z25 = 0mm
  X26 = 61.4498mm
  Y26 = 43.3213mm
  Z26 = 0mm
  X27 = 70.93mm
  Y27 = 75.0348mm
  Z27 = 0mm
  X28 = 78.5319mm
  Y28 = 88.7378mm
  Z28 = 0mm
  X29 = 77.3378mm
  Y29 = 89.4003mm
  Z29 = 0mm
  X30 = 69.736mm
  Y30 = 75.6972mm
  Z30 = 0mm
  X31 = 48.8087mm
  Y31 = 52.5985mm
  Z31 = 0mm
  X32 = 38.0308mm
  Y32 = 82.759mm
  Z32 = 0mm
  X33 = 36.3876mm
  Y33 = 98.343mm
  Z33 = 0mm
  X34 = 35.0296mm
  Y34 = 98.1998mm
  Z34 = 0mm
  X35 = 36.6728mm
  Y35 = 82.6158mm
  Z35 = 0mm
  X36 = 32.4677mm
  Y36 = 50.4403mm
  Z36 = 0mm
  X37 = 8.2168mm
  Y37 = 69.5899mm
  Z37 = 0mm
  X38 = -1.3785mm
  Y38 = 81.979mm
  Z38 = 0mm
  X39 = -2.4581mm
  Y39 = 81.1429mm
  Z39 = 0mm
  X40 = 7.1373mm
  Y40 = 68.7537mm
  Z40 = 0mm
  X41 = 21.2679mm
  Y41 = 38.3468mm
  Z41 = 0mm
  X42 = -9.5179mm
  Y42 = 51.5201mm
  Z42 = 0mm
  X43 = -23.0889mm
  Y43 = 59.3553mm
  Z43 = 0mm
  X44 = -23.7716mm
  Y44 = 58.1727mm
  Z44 = 0mm
  X45 = -10.2006mm
  Y45 = 50.3375mm
  Z45 = 0mm
  X46 = 13.2975mm
  Y46 = 32.17mm
  Z46 = 0mm
  X47 = -18.5917mm
  Y47 = 40.8944mm
  Z47 = 0mm
  X48 = -33.0693mm
  Y48 = 46.8912mm
  Z48 = 0mm
  X49 = -33.5918mm
  Y49 = 45.6297mm
  Z49 = 0mm
  X50 = -19.1143mm
  Y50 = 39.6328mm
  Z50 = 0mm
  X51 = 6.8772mm
  Y51 = 24.3241mm
  Z51 = 0mm
  X52 = -25.4818mm
  Y52 = 28.529mm
  Z52 = 0mm
  X53 = -40.6182mm
  Y53 = 32.5848mm
  Z53 = 0mm
  X54 = -40.9716mm
  Y54 = 31.2658mm
  Z54 = 0mm
  X55 = -25.8352mm
  Y55 = 27.21mm
  Z55 = 0mm
  X56 = 2.3512mm
  Y56 = 15.1539mm
  Z56 = 0mm
  X57 = -29.8109mm
  Y57 = 14.9286mm
  Z57 = 0mm
  X58 = -45.3472mm
  Y58 = 16.974mm
  Z58 = 0mm
  X59 = -45.5255mm
  Y59 = 15.6201mm
  Z59 = 0mm
  X60 = -29.9891mm
  Y60 = 13.5747mm
  Z60 = 0mm
  X61 = 0.012104mm
  Y61 = 5.1467mm
  Z61 = 0mm
  X62 = -31.3408mm
  Y62 = 0.68275mm
  Z62 = 0mm
  X63 = -47.0112mm
  Y63 = 0.68275mm
  Z63 = 0mm
geometry:
  Polyline1 = polyline((X1, Y1, Z1) (X2, Y2, Z2) (X3, Y3, Z3) (X4, Y4, Z4) (X5, Y5, Z5) (X6, Y6, Z6) (X7, Y7, Z7) (X8, Y8, Z8) (X9, Y9, Z9) (X10, Y10, Z10) (X11, Y11, Z11) (X12, Y12, Z12) (X13, Y13, Z13) (X14, Y14, Z14) (X15, Y15, Z15) (X16, Y16, Z16) (X17, Y17, Z17) (X18, Y18, Z18) (X19, Y19, Z19) (X20, Y20, Z20) (X21, Y21, Z21) (X22, Y22, Z22) (X23, Y23, Z23) (X24, Y24, Z24) (X25, Y25, Z25) (X26, Y26, Z26) (X27, Y27, Z27) (X28, Y28, Z28) (X29, Y29, Z29) (X30, Y30, Z30) (X31, Y31, Z31) (X32, Y32, Z32) (X33, Y33, Z33) (X34, Y34, Z34) (X35, Y35, Z35) (X36, Y36, Z36) (X37, Y37, Z37) (X38, Y38, Z38) (X39, Y39, Z39) (X40, Y40, Z40) (X41, Y41, Z41) (X42, Y42, Z42) (X43, Y43, Z43) (X44, Y44, Z44) (X45, Y45, Z45) (X46, Y46, Z46) (X47, Y47, Z47) (X48, Y48, Z48) (X49, Y49, Z49) (X50, Y50, Z50) (X51, Y51, Z51) (X52, Y52, Z52) (X53, Y53, Z53) (X54, Y54, Z54) (X55, Y55, Z55) (X56, Y56, Z56) (X57, Y57, Z57) (X58, Y58, Z58) (X59, Y59, Z59) (X60, Y60, Z60) (X61, Y61, Z61) (X62, Y62, Z62) (X63, Y63, Z63) (X63, -Y63, Z63) (X62, -Y62, Z62) (X61, -Y61, Z61) (X60, -Y60, Z60) (X59, -Y59, Z59) (X58, -Y58, Z58) (X57, -Y57, Z57) (X56, -Y56, Z56) (X55, -Y55, Z55) (X54, -Y54, Z54) (X53, -Y53, Z53) (X52, -Y52, Z52) (X51, -Y51, Z51) (X50, -Y50, Z50) (X49, -Y49, Z49) (X48, -Y48, Z48) (X47, -Y47, Z47) (X46, -Y46, Z46) (X45, -Y45, Z45) (X44, -Y44, Z44) (X43, -Y43, Z43) (X42, -Y42, Z42) (X41, -Y41, Z41) (X40, -Y40, Z40) (X39, -Y39, Z39) (X38, -Y38, Z38) (X37, -Y37, Z37) (X36, -Y36, Z36) (X35, -Y35, Z35) (X34, -Y34, Z34) (X33, -Y33, Z33) (X32, -Y32, Z32) (X31, -Y31, Z31) (X30, -Y30, Z30) (X29, -Y29, Z29) (X28, -Y28, Z28) (X27, -Y27, Z27) (X26, -Y26, Z26) (X25, -Y25, Z25) (X24, -Y24, Z24) (X23, -Y23, Z23) (X22, -Y22, Z22) (X21, -Y21, Z21) (X20, -Y20, Z20) (X19, -Y19, Z19) (X18, -Y18, Z18) (X17, -Y17, Z17) (X16, -Y16, Z16) (X15, -Y15, Z15) (X14, -Y14, Z14) (X13, -Y13, Z13) (X12, -Y12, Z12) (X11, -Y11, Z11) (X10, -Y10, Z10) (X9, -Y9, Z9) (X8, -Y8, Z8) (X7, -Y7, Z7) (X6, -Y6, Z6) (X5, -Y5, Z5) (X4, -Y4, Z4) (X3, -Y3, Z3) (X2, -Y2, Z2) (X1, -Y1, Z1), closed, covered)
mesh:
  initial mesh: GlobalSurfApproximation{SurfDevChoice=0 NormalDevChoice=1 AspectRatioChoice=1 SetFacePreservationLevel=0}
