# Ansys Electronics Desktop project, version 2024.2
materials:
  vacuum: permittivity=1
  Rogers RO4350 (tm): permittivity=3.66 dielectric_loss_tangent=0.004

design Rotman (HFSS, HFSS Modal Network, model units mm)
options: Calculate_Lossy_Dielectrics Save_Adaptive_support_files
variables:
  X1 = 78.4823mm
  Y1 = 0mm
  Z1 = 0mm
  X2 = 125.193mm
  Y2 = 6.155mm
  Z2 = 0mm
  X3 = 140.8332mm
  Y3 = 7.1285mm
  Z3 = 0mm
  X4 = 140.7483mm
  Y4 = 8.4918mm
  Z4 = 0mm
  X5 = 125.1082mm
  Y5 = 7.5184mm
  Z5 = 0mm
  X6 = 77.9919mm
  Y6 = 7.8478mm
  Z6 = 0mm
  X7 = 123.588mm
  Y7 = 19.716mm
  Z7 = 0mm
  X8 = 138.9896mm
  Y8 = 22.606mm
  Z8 = 0mm
  X9 = 138.7377mm
  Y9 = 23.9485mm
  Z9 = 0mm
  X10 = 123.3361mm
  Y10 = 21.0586mm
  Z10 = 0mm
  X11 = 76.5242mm
  Y11 = 15.6332mm
  Z11 = 0mm
  X12 = 120.3657mm
  Y12 = 32.9014mm
  Z12 = 0mm
  X13 = 135.3124mm
  Y13 = 37.6087mm
  Z13 = 0mm
  X14 = 134.902mm
  Y14 = 38.9116mm
  Z14 = 0mm
  X15 = 119.9554mm
  Y15 = 34.2043mm
  Z15 = 0mm
  X16 = 74.0986mm
  Y16 = 23.3083mm
  Z16 = 0mm
  X17 = 115.6714mm
  Y17 = 45.5163mm
  Z17 = 0mm
  X18 = 129.9875mm
  Y18 = 51.889mm
  Z18 = 0mm
  X19 = 129.432mm
  Y19 = 53.1369mm
  Z19 = 0mm
  X20 = 115.1159mm
  Y20 = 46.7643mm
  Z20 = 0mm
  X21 = 70.7948mm
  Y21 = 30.7303mm
  Z21 = 0mm
  X22 = 101.8641mm
  Y22 = 67.1463mm
  Z22 = 0mm
  X23 = 112.8012mm
  Y23 = 78.3686mm
  Z23 = 0mm
  X24 = 111.823mm
  Y24 = 79.322mm
  Z24 = 0mm
  X25 = 100.8858mm
  Y25 = 68.0997mm
  Z25 = 0mm
  X26 = 66.3323mm
  Y26 = 37.1817mm
  Z26 = 0mm
  X27 = 95.3741mm
  Y27 = 75.1705mm
  Z27 = 0mm
  X28 = 105.6972mm
  Y28 = 86.9602mm
  Z28 = 0mm
  X29 = 104.6695mm
  Y29 = 87.86mm
  Z29 = 0mm
  X30 = 94.3464mm
  Y30 = 76.0704mm
  Z30 = 0mm
  X31 = 61.4498mm
  Y31 = 43.3213mm
  Z31 = 0mm
  X32 = 85.8115mm
  Y32 = 84.3468mm
  Z32 = 0mm
  X33 = 94.7039mm
  Y33 = 97.2498mm
  Z33 = 0mm
  X34 = 93.5791mm
  Y34 = 98.025mm
  Z34 = 0mm
  X35 = 84.6867mm
  Y35 = 85.122mm
  Z35 = 0mm
  X36 = 55.6941mm
  Y36 = 48.7296mm
  Z36 = 0mm
  X37 = 71.5978mm
  Y37 = 93.5154mm
  Z37 = 0mm
  X38 = 77.8378mm
  Y38 = 107.8898mm
  Z38 = 0mm
  X39 = 76.5847mm
  Y39 = 108.4338mm
  Z39 = 0mm
  X40 = 70.3448mm
  Y40 = 94.0593mm
  Z40 = 0mm
  X41 = 48.8087mm
  Y41 = 52.5985mm
  Z41 = 0mm
  X42 = 49.1796mm
  Y42 = 99.8302mm
  Z42 = 0mm
  X43 = 50.4813mm
  Y43 = 115.4465mm
  Z43 = 0mm
  X44 = 49.12mm
  Y44 = 115.56mm
  Z44 = 0mm
  X45 = 47.8184mm
  Y45 = 99.9437mm
  Z45 = 0mm
  X46 = 40.3795mm
  Y46 = 53.4779mm
  Z46 = 0mm
  X47 = 23.4875mm
  Y47 = 97.1606mm
  Z47 = 0mm
  X48 = 18.9575mm
  Y48 = 112.162mm
  Z48 = 0mm
  X49 = 17.6498mm
  Y49 = 111.7671mm
  Z49 = 0mm
  X50 = 22.1798mm
  Y50 = 96.7657mm
  Z50 = 0mm
  X51 = 32.4677mm
  Y51 = 50.4403mm
  Z51 = 0mm
  X52 = 5.4013mm
  Y52 = 88.3394mm
  Z52 = 0mm
  X53 = -2.7391mm
  Y53 = 101.7296mm
  Z53 = 0mm
  X54 = -3.9063mm
  Y54 = 101.02mm
  Z54 = 0mm
  X55 = 4.234mm
  Y55 = 87.6298mm
  Z55 = 0mm
  X56 = 26.0098mm
  Y56 = 45.1881mm
  Z56 = 0mm
  X57 = -8.6571mm
  Y57 = 75.9361mm
  Z57 = 0mm
  X58 = -19.5856mm
  Y58 = 87.1668mm
  Z58 = 0mm
  X59 = -20.5646mm
  Y59 = 86.2142mm
  Z59 = 0mm
  X60 = -9.6361mm
  Y60 = 74.9834mm
  Z60 = 0mm
  X61 = 21.2679mm
  Y61 = 38.3468mm
  Z61 = 0mm
  X62 = -23.0887mm
  Y62 = 59.3555mm
  Z62 = 0mm
  X63 = -36.6597mm
  Y63 = 67.1907mm
  Z63 = 0mm
  X64 = -37.3427mm
  Y64 = 66.0077mm
  Z64 = 0mm
  X65 = -23.7717mm
  Y65 = 58.1725mm
  Z65 = 0mm
  X66 = 13.2975mm
  Y66 = 32.17mm
  Z66 = 0mm
  X67 = -33.0692mm
  Y67 = 46.8914mm
  Z67 = 0mm
  X68 = -47.5467mm
  Y68 = 52.8882mm
  Z68 = 0mm
  X69 = -48.0695mm
  Y69 = 51.6262mm
  Z69 = 0mm
  X70 = -33.5919mm
  Y70 = 45.6294mm
  Z70 = 0mm
  X71 = 6.8772mm
  Y71 = 24.3241mm
  Z71 = 0mm
  X72 = -40.6181mm
  Y72 = 32.5851mm
  Z72 = 0mm
  X73 = -55.7546mm
  Y73 = 36.6409mm
  Z73 = 0mm
  X74 = -56.1081mm
  Y74 = 35.3214mm
  Z74 = 0mm
  X75 = -40.9717mm
  Y75 = 31.2656mm
  Z75 = 0mm
  X76 = 2.3512mm
  Y76 = 15.1539mm
  Z76 = 0mm
  X77 = -45.3472mm
  Y77 = 16.9742mm
  Z77 = 0mm
  X78 = -60.8835mm
  Y78 = 19.0196mm
  Z78 = 0mm
  X79 = -61.0618mm
  Y79 = 17.6653mm
  Z79 = 0mm
  X80 = -45.5255mm
  Y80 = 15.6199mm
  Z80 = 0mm
  X81 = 0.012104mm
  Y81 = 5.1467mm
  Z81 = 0mm
  X82 = -47.0112mm
  Y82 = 0.683mm
  Z82 = 0mm
  X83 = -62.6816mm
  Y83 = 0.683mm
  Z83 = 0mm
  SubW = 300mm
  SubL = 250mm
  SubTh = 0.688mm
  W4 = 1.031mm
  W3 = 0.5655mm
  W2 = 0.2113mm
  W1 = 0.0239mm
geometry:
  Polyline1 = polyline((X1, Y1, Z1) (X2, Y2, Z2) (X3, Y3, Z3) (X4, Y4, Z4) (X5, Y5, Z5) (X6, Y6, Z6) (X7, Y7, Z7) (X8, Y8, Z8) (X9, Y9, Z9) (X10, Y10, Z10) (X11, Y11, Z11) (X12, Y12, Z12) (X13, Y13, Z13) (X14, Y14, Z14) (X15, Y15, Z15) (X16, Y16, Z16) (X17, Y17, Z17) (X18, Y18, Z18) (X19, Y19, Z19) (X20, Y20, Z20) (X21, Y21, Z21) (X22, Y22, Z22) (X23, Y23, Z23) (X24, Y24, Z24) (X25, Y25, Z25) (X26, Y26, Z26) (X27, Y27, Z27) (X28, Y28, Z28) (X29, Y29, Z29) (X30, Y30, Z30) (X31, Y31, Z31) (X32, Y32, Z32) (X33, Y33, Z33) (X34, Y34, Z34) (X35, Y35, Z35) (X36, Y36, Z36) (X37, Y37, Z37) (X38, Y38, Z38) (X39, Y39, Z39) (X40, Y40, Z40) (X41, Y41, Z41) (X42, Y42, Z42) (X43, Y43, Z43) (X44, Y44, Z44) (X45, Y45, Z45) (X46, Y46, Z46) (X47, Y47, Z47) (X48, Y48, Z48) (X49, Y49, Z49) (X50, Y50, Z50) (X51, Y51, Z51) (X52, Y52, Z52) (X53, Y53, Z53) (X54, Y54, Z54) (X55, Y55, Z55) (X56, Y56, Z56) (X57, Y57, Z57) (X58, Y58, Z58) (X59, Y59, Z59) (X60, Y60, Z60) (X61, Y61, Z61) (X62, Y62, Z62) (X63, Y63, Z63) (X64, Y64, Z64) (X65, Y65, Z65) (X66, Y66, Z66) (X67, Y67, Z67) (X68, Y68, Z68) (X69, Y69, Z69) (X70, Y70, Z70) (X71, Y71, Z71) (X72, Y72, Z72) (X73, Y73, Z73) (X74, Y74, Z74) (X75, Y75, Z75) (X76, Y76, Z76) (X77, Y77, Z77) (X78, Y78, Z78) (X79, Y79, Z79) (X80, Y80, Z80) (X81, Y81, Z81) (X82, Y82, Z82) (X83, Y83, Z83) (X83, -Y83, Z83) (X82, -Y82, Z82) (X81, -Y81, Z81) (X80, -Y80, Z80) (X79, -Y79, Z79) (X78, -Y78, Z78) (X77, -Y77, Z77) (X76, -Y76, Z76) (X75, -Y75, Z75) (X74, -Y74, Z74) (X73, -Y73, Z73) (X72, -Y72, Z72) (X71, -Y71, Z71) (X70, -Y70, Z70) (X69, -Y69, Z69) (X68, -Y68, Z68) (X67, -Y67, Z67) (X66, -Y66, Z66) (X65, -Y65, Z65) (X64, -Y64, Z64) (X63, -Y63, Z63) (X62, -Y62, Z62) (X61, -Y61, Z61) (X60, -Y60, Z60) (X59, -Y59, Z59) (X58, -Y58, Z58) (X57, -Y57, Z57) (X56, -Y56, Z56) (X55, -Y55, Z55) (X54, -Y54, Z54) (X53, -Y53, Z53) (X52, -Y52, Z52) (X51, -Y51, Z51) (X50, -Y50, Z50) (X49, -Y49, Z49) (X48, -Y48, Z48) (X47, -Y47, Z47) (X46, -Y46, Z46) (X45, -Y45, Z45) (X44, -Y44, Z44) (X43, -Y43, Z43) (X42, -Y42, Z42) (X41, -Y41, Z41) (X40, -Y40, Z40) (X39, -Y39, Z39) (X38, -Y38, Z38) (X37, -Y37, Z37) (X36, -Y36, Z36) (X35, -Y35, Z35) (X34, -Y34, Z34) (X33, -Y33, Z33) (X32, -Y32, Z32) (X31, -Y31, Z31) (X30, -Y30, Z30) (X29, -Y29, Z29) (X28, -Y28, Z28) (X27, -Y27, Z27) (X26, -Y26, Z26) (X25, -Y25, Z25) (X24, -Y24, Z24) (X23, -Y23, Z23) (X22, -Y22, Z22) (X21, -Y21, Z21) (X20, -Y20, Z20) (X19, -Y19, Z19) (X18, -Y18, Z18) (X17, -Y17, Z17) (X16, -Y16, Z16) (X15, -Y15, Z15) (X14, -Y14, Z14) (X13, -Y13, Z13) (X12, -Y12, Z12) (X11, -Y11, Z11) (X10, -Y10, Z10) (X9, -Y9, Z9) (X8, -Y8, Z8) (X7, -Y7, Z7) (X6, -Y6, Z6) (X5, -Y5, Z5) (X4, -Y4, Z4) (X3, -Y3, Z3) (X2, -Y2, Z2) (X1, -Y1, Z1), closed, covered)
  Box1 [Rogers RO4350 (tm)] = box(corner=(-SubW/2, -SubL/2, 0mm), size=(SubW, SubL, SubTh))
  Polyline1.move(0mm, 0mm, SubTh)
  Polyline1.move(-40.89743mm, 0mm, -6.6613381e-16mm)
  Polyline1.thicken(-SubTh)
  Polyline1_ObjectFromFace1..Polyline1_ObjectFromFace33 = object_from(Polyline1_ObjectFromFace29_ObjectFromFace1.face(at (71.4147, -78.8453, 0.344), at (64.2859, -87.4101, 0.344), at (36.3138, -108.162, 0.344), at (53.2441, -97.6374, 0.344), at (8.90322, -115.503, 0.344), at (-22.5938, -111.965, 0.344), at (-44.2201, -101.375, 0.344), at (-60.9725, -86.6905, 0.344), at (-77.8986, -66.5992, 0.344), at (-88.7055, -52.2572, 0.344), at (-96.8288, -35.9811, 0.344), at (-101.87, -18.3424, 0.344)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))
  [Polyline1_ObjectFromFace26, Polyline1_ObjectFromFace33].thicken(W4)
  [Polyline1_ObjectFromFace32, Polyline1_ObjectFromFace27].thicken(W3)
  [Polyline1_ObjectFromFace28, Polyline1_ObjectFromFace31].thicken(W2)
  [Polyline1_ObjectFromFace29, Polyline1_ObjectFromFace30].thicken(W1)
  Polyline1_ObjectFromFace26_ObjectFromFace1 = object_from(Polyline1_ObjectFromFace26.face(at (89.7542, 52.9322, 0.344)))
  Polyline1_ObjectFromFace26.delete()
  Polyline1_ObjectFromFace27_ObjectFromFace1 = object_from(Polyline1_ObjectFromFace27.face(at (94.7491, 38.43, 0.344)))
  Polyline1_ObjectFromFace27.delete()
  Polyline1_ObjectFromFace28_ObjectFromFace1 = object_from(Polyline1_ObjectFromFace28.face(at (98.1739, 23.3162, 0.344)))
  Polyline1_ObjectFromFace28.delete()
  Polyline1_ObjectFromFace29_ObjectFromFace1 = object_from(Polyline1_ObjectFromFace29.face(at (99.9172, 7.81164, 0.344)))
  Polyline1_ObjectFromFace29.delete()
  Polyline1_ObjectFromFace30_ObjectFromFace1 = object_from(Polyline1_ObjectFromFace30.face(at (99.9172, -7.81164, 0.344)))
  Polyline1_ObjectFromFace30.delete()
  Polyline1_ObjectFromFace31_ObjectFromFace1 = object_from(Polyline1_ObjectFromFace31.face(at (98.1739, -23.3162, 0.344)))
  Polyline1_ObjectFromFace31.delete()
  Polyline1_ObjectFromFace32_ObjectFromFace1 = object_from(Polyline1_ObjectFromFace32.face(at (94.7491, -38.43, 0.344)))
  Polyline1_ObjectFromFace32.delete()
  Polyline1_ObjectFromFace33_ObjectFromFace1 = object_from(Polyline1_ObjectFromFace33.face(at (89.7542, -52.9322, 0.344)))
  Polyline1_ObjectFromFace33.delete()
  [Polyline1_ObjectFromFace26_ObjectFromFace1, Polyline1_ObjectFromFace33_ObjectFromFace1].thicken(-W4)
  [Polyline1_ObjectFromFace27_ObjectFromFace1, Polyline1_ObjectFromFace32_ObjectFromFace1].thicken(-W3)
  [Polyline1_ObjectFromFace28_ObjectFromFace1, Polyline1_ObjectFromFace31_ObjectFromFace1].thicken(-W2)
  [Polyline1_ObjectFromFace29_ObjectFromFace1, Polyline1_ObjectFromFace30_ObjectFromFace1].thicken(-W1)
  Polyline1_ObjectFromFace26_ObjectFromFace1.unite(Polyline1_ObjectFromFace27_ObjectFromFace1, Polyline1_ObjectFromFace28_ObjectFromFace1, Polyline1_ObjectFromFace30_ObjectFromFace1, Polyline1, Polyline1_ObjectFromFace31_ObjectFromFace1, Polyline1_ObjectFromFace32_ObjectFromFace1, Polyline1_ObjectFromFace33_ObjectFromFace1)
  Polyline1_ObjectFromFace29_ObjectFromFace1.unite(Polyline1_ObjectFromFace26_ObjectFromFace1)
  Polyline1_ObjectFromFace29_ObjectFromFace1_ObjectFromFace1 = object_from(Polyline1_ObjectFromFace29_ObjectFromFace1.face(at (-1.57098, -0.609897, 0.688)))
  Polyline1_ObjectFromFace29_ObjectFromFace1.delete()
  RadiatingSurface [vacuum] = region(absolute_offset=10mm on all sides)
  Polyline1_ObjectFromFace29_ObjectFromFace1_ObjectFromFace1_ObjectFromFace1 = object_from(Polyline1_ObjectFromFace29_ObjectFromFace1_ObjectFromFace1.face)
  Polyline1_ObjectFromFace29_ObjectFromFace1_ObjectFromFace1.delete()
  Polyline1_ObjectFromFace29_ObjectFromFace1_ObjectFromFace1_ObjectFromFace1.thicken(-SubTh)
  Polyline1_ObjectFromFace29_ObjectFromFace1_ObjectFromFace1_ObjectFromFace1_ObjectFromFace1..Polyline1_ObjectFromFace29_ObjectFromFace1_ObjectFromFace1_ObjectFromFace1_ObjectFromFace8 = object_from(Polyline1_ObjectFromFace29_ObjectFromFace1_ObjectFromFace1_ObjectFromFace1.face(at (89.7542, 52.9322, 0.344), at (94.7491, 38.43, 0.344), at (98.1739, 23.3162, 0.344), at (99.9172, 7.81164, 0.344), at (99.9172, -7.81164, 0.344), at (98.1739, -23.3162, 0.344), at (94.7491, -38.43, 0.344), at (89.7542, -52.9322, 0.344)))
  Polyline1_ObjectFromFace29_ObjectFromFace1_ObjectFromFace1_ObjectFromFace1_ObjectFromFace9 = object_from(Polyline1_ObjectFromFace29_ObjectFromFace1_ObjectFromFace1_ObjectFromFace1.face(at (-1.57098, -0.609897, 0.688)))
  Polyline1_ObjectFromFace29_ObjectFromFace1_ObjectFromFace1_ObjectFromFace1.delete()
boundaries and excitations:
  LumpRLC1: Lumped RLC Faces=Polyline1_ObjectFromFace25.face CurrentLine{(71.41467, 78.8453, 0.688) -> (71.41467, 78.8453, 0)} RLC_Type=Parallel Resistance=50ohm
  LumpRLC2: Lumped RLC Faces=Polyline1_ObjectFromFace24.face CurrentLine{(64.28592, 87.4101, 0.688) -> (64.28592, 87.4101, 0)} RLC_Type=Parallel Resistance=50ohm
  LumpRLC3: Lumped RLC Faces=Polyline1_ObjectFromFace23.face CurrentLine{(53.24407, 97.6374, 0.688) -> (53.24407, 97.6374, 0)} RLC_Type=Parallel Resistance=50ohm
  LumpRLC4: Lumped RLC Faces=Polyline1_ObjectFromFace22.face CurrentLine{(36.31382, 108.1618, 0.688) -> (36.31382, 108.1618, 0)} RLC_Type=Parallel Resistance=50ohm
  LumpRLC5: Lumped RLC Faces=Polyline1_ObjectFromFace21.face CurrentLine{(8.9032198, 115.50325, 0.688) -> (8.9032198, 115.50325, 0)} RLC_Type=Parallel Resistance=50ohm
  LumpRLC6: Lumped RLC Faces=Polyline1_ObjectFromFace20.face CurrentLine{(-22.59378, 111.96455, 0.688) -> (-22.59378, 111.96455, 0)} RLC_Type=Parallel Resistance=50ohm
  LumpRLC7: Lumped RLC Faces=Polyline1_ObjectFromFace19.face CurrentLine{(-44.22013, 101.3748, 0.688) -> (-44.22013, 101.3748, 0)} RLC_Type=Parallel Resistance=50ohm
  LumpRLC8: Lumped RLC Faces=Polyline1_ObjectFromFace18.face CurrentLine{(-60.97253, 86.6905, 0.688) -> (-60.97253, 86.6905, 0)} RLC_Type=Parallel Resistance=50ohm
  LumpRLC9: Lumped RLC Faces=Polyline1_ObjectFromFace8.face CurrentLine{(-60.97253, -86.6905, 0) -> (-60.97253, -86.6905, 0.688)} RLC_Type=Parallel Resistance=50ohm
  LumpRLC10: Lumped RLC Faces=Polyline1_ObjectFromFace7.face CurrentLine{(-44.22013, -101.3748, 0) -> (-44.22013, -101.3748, 0.688)} RLC_Type=Parallel Resistance=50ohm
  LumpRLC11: Lumped RLC Faces=Polyline1_ObjectFromFace6.face CurrentLine{(-22.59378, -111.96455, 0) -> (-22.59378, -111.96455, 0.688)} RLC_Type=Parallel Resistance=50ohm
  LumpRLC12: Lumped RLC Faces=Polyline1_ObjectFromFace5.face CurrentLine{(8.9032198, -115.50325, 0) -> (8.9032198, -115.50325, 0.688)} RLC_Type=Parallel Resistance=50ohm
  LumpRLC13: Lumped RLC Faces=Polyline1_ObjectFromFace3.face CurrentLine{(36.31382, -108.1618, 0) -> (36.31382, -108.1618, 0.688)} RLC_Type=Parallel Resistance=50ohm
  LumpRLC14: Lumped RLC Faces=Polyline1_ObjectFromFace4.face CurrentLine{(53.24407, -97.6374, 0) -> (53.24407, -97.6374, 0.688)} RLC_Type=Parallel Resistance=50ohm
  LumpRLC15: Lumped RLC Faces=Polyline1_ObjectFromFace2.face CurrentLine{(64.28592, -87.4101, 0) -> (64.28592, -87.4101, 0.688)} RLC_Type=Parallel Resistance=50ohm
  LumpRLC16: Lumped RLC Faces=Polyline1_ObjectFromFace1.face CurrentLine{(71.41467, -78.8453, 0) -> (71.41467, -78.8453, 0.688)} RLC_Type=Parallel Resistance=50ohm
  PerfE1: Perfect E Faces=Box1.face(-z)
  Open1: Radiation Objects=RadiatingSurface
  PerfE2: Perfect E Objects=Polyline1_ObjectFromFace29_ObjectFromFace1_ObjectFromFace1_ObjectFromFace1_ObjectFromFace9
  1: Lumped Port Faces=Polyline1_ObjectFromFace17.face LumpedPortType=Modal Modes{Mode1{IntLine{(-77.89863, 66.5992, 0) -> (-77.89863, 66.5992, 0.688)} CharImp=Zpi RenormImp=50ohm}} Impedance=50ohm
  2: Lumped Port Faces=Polyline1_ObjectFromFace16.face LumpedPortType=Modal Modes{Mode1{IntLine{(-88.70553, 52.2572, 0) -> (-88.70553, 52.2572, 0.688)} CharImp=Zpi RenormImp=50ohm}} Impedance=50ohm
  3: Lumped Port Faces=Polyline1_ObjectFromFace15.face LumpedPortType=Modal Modes{Mode1{IntLine{(-96.82878, 35.98115, 0) -> (-96.82878, 35.98115, 0.688)} CharImp=Zpi RenormImp=50ohm}} Impedance=50ohm
  4: Lumped Port Faces=Polyline1_ObjectFromFace14.face LumpedPortType=Modal Modes{Mode1{IntLine{(-101.87008, 18.34245, 0) -> (-101.87008, 18.34245, 0.688)} CharImp=Zpi RenormImp=50ohm}} Impedance=50ohm
  5: Lumped Port Faces=Polyline1_ObjectFromFace13.face LumpedPortType=Modal Modes{Mode1{IntLine{(-103.57903, 0, 0) -> (-103.57903, 0, 0.688)} CharImp=Zpi RenormImp=50ohm}} Impedance=50ohm
  6: Lumped Port Faces=Polyline1_ObjectFromFace12.face LumpedPortType=Modal Modes{Mode1{IntLine{(-101.87008, -18.34245, 0) -> (-101.87008, -18.34245, 0.688)} CharImp=Zpi RenormImp=50ohm}} Impedance=50ohm
  7: Lumped Port Faces=Polyline1_ObjectFromFace11.face LumpedPortType=Modal Modes{Mode1{IntLine{(-96.82878, -35.98115, 0) -> (-96.82878, -35.98115, 0.688)} CharImp=Zpi RenormImp=50ohm}} Impedance=50ohm
  8: Lumped Port Faces=Polyline1_ObjectFromFace10.face LumpedPortType=Modal Modes{Mode1{IntLine{(-88.70553, -52.2572, 0) -> (-88.70553, -52.2572, 0.688)} CharImp=Zpi RenormImp=50ohm}} Impedance=50ohm
  9: Lumped Port Faces=Polyline1_ObjectFromFace9.face LumpedPortType=Modal Modes{Mode1{IntLine{(-77.89863, -66.5992, 0) -> (-77.89863, -66.5992, 0.688)} CharImp=Zpi RenormImp=50ohm}} Impedance=50ohm
  10: Lumped Port Faces=Polyline1_ObjectFromFace29_ObjectFromFace1_ObjectFromFace1_ObjectFromFace1_ObjectFromFace8.face LumpedPortType=Default Modes{Mode1{IntLine{(89.754213, -52.932232, 0.688) -> (89.754213, -52.932232, 0)} CharImp=Zpi RenormImp=50ohm}} Impedance=50ohm
  11: Lumped Port Faces=Polyline1_ObjectFromFace29_ObjectFromFace1_ObjectFromFace1_ObjectFromFace1_ObjectFromFace7.face LumpedPortType=Default Modes{Mode1{IntLine{(94.749145, -38.430047, 0.688) -> (94.749145, -38.430047, 0)} CharImp=Zpi RenormImp=50ohm}} Impedance=50ohm
  12: Lumped Port Faces=Polyline1_ObjectFromFace29_ObjectFromFace1_ObjectFromFace1_ObjectFromFace1_ObjectFromFace6.face LumpedPortType=Default Modes{Mode1{IntLine{(98.173896, -23.316217, 0.688) -> (98.173896, -23.316217, 0)} CharImp=Zpi RenormImp=50ohm}} Impedance=50ohm
  13: Lumped Port Faces=Polyline1_ObjectFromFace29_ObjectFromFace1_ObjectFromFace1_ObjectFromFace1_ObjectFromFace5.face LumpedPortType=Default Modes{Mode1{IntLine{(99.917174, -7.8116355, 0.688) -> (99.917174, -7.8116355, 0)} CharImp=Zpi RenormImp=50ohm}} Impedance=50ohm
  14: Lumped Port Faces=Polyline1_ObjectFromFace29_ObjectFromFace1_ObjectFromFace1_ObjectFromFace1_ObjectFromFace4.face LumpedPortType=Default Modes{Mode1{IntLine{(99.917174, 7.8116355, 0.688) -> (99.917174, 7.8116355, 0)} CharImp=Zpi RenormImp=50ohm}} Impedance=50ohm
  15: Lumped Port Faces=Polyline1_ObjectFromFace29_ObjectFromFace1_ObjectFromFace1_ObjectFromFace1_ObjectFromFace3.face LumpedPortType=Default Modes{Mode1{IntLine{(98.173896, 23.316217, 0.688) -> (98.173896, 23.316217, 0)} CharImp=Zpi RenormImp=50ohm}} Impedance=50ohm
  16: Lumped Port Faces=Polyline1_ObjectFromFace29_ObjectFromFace1_ObjectFromFace1_ObjectFromFace1_ObjectFromFace2.face LumpedPortType=Default Modes{Mode1{IntLine{(94.749145, 38.430047, 0.688) -> (94.749145, 38.430047, 0)} CharImp=Zpi RenormImp=50ohm}} Impedance=50ohm
  17: Lumped Port Faces=Polyline1_ObjectFromFace29_ObjectFromFace1_ObjectFromFace1_ObjectFromFace1_ObjectFromFace1.face LumpedPortType=Default Modes{Mode1{IntLine{(89.754213, 52.932232, 0.688) -> (89.754213, 52.932232, 0)} CharImp=Zpi RenormImp=50ohm}} Impedance=50ohm
setups:
  Setup1: HfssDriven Frequency=10GHz MaxDeltaS=0.02 MaximumPasses=18 MinimumPasses=1 MinimumConvergedPasses=2 PercentRefinement=30 BasisOrder=1 PortAccuracy=2 DrivenSolverType="Direct Solver"
    sweep Sweep: 5GHz to 15GHz, 11 points; Type=Interpolating InterpTolerance=0.5 InterpMaxSolns=250 InterpUsePortImped=false PassivityErrorTolerance=0.0001
source amplitudes:
  1:1: 1W 0deg
  2:1, 3:1, 4:1, 5:1, 6:1, 7:1, 8:1, 9:1, 10:1, 11:1, 12:1, 13:1, 14:1, 15:1, 16:1, 17:1: 0W 0deg
radiation setups:
  3D: Infinite Sphere Theta=0deg..180deg step 2deg Phi=-180deg..180deg step 2deg
  Elevation: Infinite Sphere Theta=-180deg..180deg step 1deg Phi=0deg..90deg step 90deg
  Azimuth: Infinite Sphere Theta=90deg..90deg step 0deg Phi=-180deg..180deg step 1deg
